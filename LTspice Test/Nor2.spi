*** SPICE deck for cell Nor2{lay} from library Project
*** Created on Per Ara 18, 2025 13:57:49
*** Last revised on Per Ara 18, 2025 14:08:28
*** Written on Per Ara 18, 2025 14:08:31 by Electric VLSI Design System, version 9.07
*** Layout tech: mocmos, foundry MOSIS
*** UC SPICE *** , MIN_RESIST 4.0, MIN_CAPAC 0.1FF

*** TOP LEVEL CELL: Nor2{lay}
Mnmos@1 y b gnd gnd N L=0.6U W=3U AS=16.875P AD=7.5P PS=25.5U PD=9.5U
Mnmos@2 gnd a y gnd N L=0.6U W=3U AS=7.5P AD=16.875P PS=9.5U PD=25.5U
Mpmos@0 net@5 b vdd vdd P L=0.6U W=6U AS=37.8P AD=5.4P PS=47.1U PD=7.8U
Mpmos@1 y a net@5 vdd P L=0.6U W=6U AS=5.4P AD=7.5P PS=7.8U PD=9.5U

* Spice Code nodes in cell cell 'Nor2{lay}'
.include C:\VLSI\C5_models.txt
Vdd vdd 0 DC 5
Va a 0 PULSE(0 5 40ns 1p 1p 40n 80n)
Vb b 0 PULSE(0 5 20ns 1p 1p 20n 40n)
.tran 80n
.end
.END
