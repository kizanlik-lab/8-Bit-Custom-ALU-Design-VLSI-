*** SPICE deck for cell Nand2{sch} from library Project
*** Created on Cmt Ara 13, 2025 23:16:07
*** Last revised on Paz Ara 28, 2025 02:24:07
*** Written on Paz Ara 28, 2025 02:24:10 by Electric VLSI Design System, version 9.07
*** Layout tech: mocmos, foundry MOSIS
*** UC SPICE *** , MIN_RESIST 4.0, MIN_CAPAC 0.1FF

.global gnd vdd

*** TOP LEVEL CELL: Nand2{sch}
Mnmos-4@0 y a net@54 gnd N L=0.6U W=3U
Mnmos-4@1 net@54 b gnd gnd N L=0.6U W=3U
Mpmos-4@0 vdd b y vdd P L=0.6U W=3U
Mpmos-4@1 vdd a y vdd P L=0.6U W=3U

* Spice Code nodes in cell cell 'Nand2{sch}'
.include C:\VLSI\C5_models.txt
Vdd vdd 0 DC 5
Va a 0 PULSE(0 5 40ns 1p 1p 40n 80n)
Vb b 0 PULSE(0 5 20ns 1p 1p 20n 40n)
.tran 80n
.end
.END
