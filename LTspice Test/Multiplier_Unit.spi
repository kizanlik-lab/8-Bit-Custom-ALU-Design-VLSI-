*** SPICE deck for cell Multiplier_Unit{lay} from library Project
*** Created on Paz Ara 21, 2025 21:33:01
*** Last revised on Cmt Ara 27, 2025 00:42:45
*** Written on Cmt Ara 27, 2025 00:42:48 by Electric VLSI Design System, version 9.07
*** Layout tech: mocmos, foundry MOSIS
*** UC SPICE *** , MIN_RESIST 4.0, MIN_CAPAC 0.1FF

*** SUBCIRCUIT Project__Inverter FROM CELL Inverter{lay}
.SUBCKT Project__Inverter gnd in out vdd
Mnmos@0 out in gnd gnd N L=0.6U W=3U AS=42.75P AD=10.125P PS=40.5U PD=13.5U
Mpmos@0 out in vdd vdd P L=0.6U W=6U AS=49.5P AD=10.125P PS=46.5U PD=13.5U

* Spice Code nodes in cell cell 'Inverter{lay}'
.include C:\VLSI\C5_models.txt
.ENDS Project__Inverter

*** SUBCIRCUIT Project__Nand2 FROM CELL Nand2{lay}
.SUBCKT Project__Nand2 a b gnd vdd y
Mnmos@0 net@55 b gnd gnd N L=0.6U W=4.5U AS=64.125P AD=4.05P PS=55.5U PD=6.3U
Mnmos@1 y a net@55 gnd N L=0.6U W=4.5U AS=4.05P AD=7.875P PS=6.3U PD=9.5U
Mpmos@0 y b vdd vdd P L=0.6U W=4.5U AS=37.125P AD=7.875P PS=34.5U PD=9.5U
Mpmos@1 vdd a y vdd P L=0.6U W=4.5U AS=7.875P AD=37.125P PS=9.5U PD=34.5U

* Spice Code nodes in cell cell 'Nand2{lay}'
.include C:\VLSI\C5_models.txt
.ENDS Project__Nand2

*** SUBCIRCUIT Project__And2_1out FROM CELL And2_1out{lay}
.SUBCKT Project__And2_1out a b gnd vdd y
XInverter@0 gnd net@12 y vdd Project__Inverter
XNAND2@0 a b gnd vdd net@12 Project__Nand2
.ENDS Project__And2_1out

*** SUBCIRCUIT Project__And2_2out FROM CELL And2_2out{lay}
.SUBCKT Project__And2_2out a b gnd vdd y y_bar
XInverter@0 gnd y_bar y vdd Project__Inverter
XNAND2@0 a b gnd vdd y_bar Project__Nand2
.ENDS Project__And2_2out

*** SUBCIRCUIT Project__Mux FROM CELL Mux{lay}
.SUBCKT Project__Mux gnd in0 in1 out sel sel_bar vdd
Mnmos@8 out sel_bar in0 gnd N L=0.6U W=3U AS=10.125P AD=6.75P PS=13.5U PD=7.5U
Mnmos@9 in1 sel out gnd N L=0.6U W=3U AS=6.75P AD=10.125P PS=7.5U PD=13.5U
Mpmos@9 out sel in0 vdd P L=0.6U W=6U AS=10.125P AD=6.75P PS=13.5U PD=7.5U
Mpmos@10 in1 sel_bar out vdd P L=0.6U W=6U AS=6.75P AD=10.125P PS=7.5U PD=13.5U

* Spice Code nodes in cell cell 'Mux{lay}'
.include C:\VLSI\C5_models.txt
.ENDS Project__Mux

*** SUBCIRCUIT Project__Xor FROM CELL Xor{lay}
.SUBCKT Project__Xor a a_bar b b_bar gnd out vdd
Mnmos@0 out a_bar b gnd N L=0.6U W=3U AS=10.125P AD=6.75P PS=13.5U PD=7.5U
Mnmos@1 b_bar a out gnd N L=0.6U W=3U AS=6.75P AD=10.125P PS=7.5U PD=13.5U
Mpmos@0 out a b vdd P L=0.6U W=6U AS=10.125P AD=6.75P PS=13.5U PD=7.5U
Mpmos@1 b_bar a_bar out vdd P L=0.6U W=6U AS=6.75P AD=10.125P PS=7.5U PD=13.5U

* Spice Code nodes in cell cell 'Xor{lay}'
.include C:\VLSI\C5_models.txt
.ENDS Project__Xor

*** SUBCIRCUIT Project__Full_Adder_Multiplier FROM CELL Full_Adder_Multiplier{lay}
.SUBCKT Project__Full_Adder_Multiplier a a_bar b b_bar cin cin_bar cout gnd sum vdd
XInverter@1 gnd net@6 net@13 vdd Project__Inverter
XMux@0 gnd b cin cout net@6 net@13 vdd Project__Mux
XXor@1 a a_bar b b_bar gnd net@6 vdd Project__Xor
XXor@2 net@6 net@13 cin cin_bar gnd sum vdd Project__Xor
.ENDS Project__Full_Adder_Multiplier

*** SUBCIRCUIT Project__Multiplier_Cell_Full FROM CELL Multiplier_Cell_Full{lay}
.SUBCKT Project__Multiplier_Cell_Full cin cin_bar cout cout_bar gnd ina inb infull infull_bar sum vdd
XAnd2_2ou@0 ina inb gnd vdd net@9 net@13 Project__And2_2out
XFull_Add@0 net@9 net@13 infull infull_bar cin cin_bar cout gnd sum vdd Project__Full_Adder_Multiplier
XInverter@0 gnd cout cout_bar vdd Project__Inverter
.ENDS Project__Multiplier_Cell_Full

*** SUBCIRCUIT Project__Multiplier_Cell_Full_1Carry FROM CELL Multiplier_Cell_Full_1Carry{lay}
.SUBCKT Project__Multiplier_Cell_Full_1Carry cin cin_bar cout gnd ina inb infull infull_bar sum vdd
XAnd2_2ou@0 ina inb gnd vdd net@2 net@4 Project__And2_2out
XFull_Add@0 net@2 net@4 infull infull_bar cin cin_bar cout gnd sum vdd Project__Full_Adder_Multiplier
.ENDS Project__Multiplier_Cell_Full_1Carry

*** SUBCIRCUIT Project__Half_Adder FROM CELL Half_Adder{lay}
.SUBCKT Project__Half_Adder a a_bar b b_bar cout cout_bar gnd sum vdd
XAnd2_2ou@0 b a gnd vdd cout cout_bar Project__And2_2out
XXor@0 a a_bar b b_bar gnd sum vdd Project__Xor
.ENDS Project__Half_Adder

*** SUBCIRCUIT Project__Multiplier_Cell_Mini FROM CELL Multiplier_Cell_Mini{lay}
.SUBCKT Project__Multiplier_Cell_Mini c c_bar gnd ina inb inhalf inhalf_bar sum vdd
XAnd2_2ou@0 ina inb gnd vdd net@5 net@9 Project__And2_2out
XHalf_Add@0 net@5 net@9 inhalf inhalf_bar c c_bar gnd sum vdd Project__Half_Adder
.ENDS Project__Multiplier_Cell_Mini

*** TOP LEVEL CELL: Multiplier_Unit{lay}
XAnd2_1ou@0 a[2] en gnd vdd net@46 Project__And2_1out
XAnd2_1ou@1 a[1] en gnd vdd net@216 Project__And2_1out
XAnd2_1ou@2 a[4] en gnd vdd net@560 Project__And2_1out
XAnd2_1ou@3 a[3] en gnd vdd net@563 Project__And2_1out
XAnd2_1ou@6 a[6] en gnd vdd net@1473 Project__And2_1out
XAnd2_1ou@7 a[5] en gnd vdd net@2064 Project__And2_1out
XAnd2_1ou@9 a[7] en gnd vdd net@1511 Project__And2_1out
XAnd2_1ou@10 b[5] en gnd vdd net@340 Project__And2_1out
XAnd2_1ou@11 b[4] en gnd vdd net@335 Project__And2_1out
XAnd2_1ou@12 b[1] en gnd vdd net@317 Project__And2_1out
XAnd2_1ou@13 b[7] en gnd vdd net@350 Project__And2_1out
XAnd2_1ou@14 b[6] en gnd vdd net@345 Project__And2_1out
XAnd2_1ou@21 b[3] en gnd vdd net@328 Project__And2_1out
XAnd2_1ou@22 b[2] en gnd vdd net@323 Project__And2_1out
XAnd2_1ou@23 a[0] en gnd vdd net@2954 Project__And2_1out
XAnd2_1ou@24 b[0] en gnd vdd net@353 Project__And2_1out
XAnd2_1ou@25 net@2954 net@353 gnd vdd m[0] Project__And2_1out
XAnd2_2ou@0 net@46 net@353 gnd vdd net@367 net@369 Project__And2_2out
XAnd2_2ou@1 net@216 net@353 gnd vdd net@2912 net@2913 Project__And2_2out
XAnd2_2ou@2 net@560 net@353 gnd vdd net@688 net@689 Project__And2_2out
XAnd2_2ou@3 net@563 net@353 gnd vdd net@917 net@921 Project__And2_2out
XAnd2_2ou@6 net@1473 net@353 gnd vdd net@2191 net@2192 Project__And2_2out
XAnd2_2ou@7 net@2064 net@353 gnd vdd net@2332 net@2337 Project__And2_2out
XAnd2_2ou@9 net@1511 net@353 gnd vdd net@3125 net@3131 Project__And2_2out
XInverter@0 gnd net@64 net@389 vdd Project__Inverter
XInverter@2 gnd net@102 net@414 vdd Project__Inverter
XInverter@3 gnd net@128 net@444 vdd Project__Inverter
XInverter@4 gnd net@113 net@475 vdd Project__Inverter
XInverter@6 gnd net@149 net@505 vdd Project__Inverter
XInverter@7 gnd net@189 net@539 vdd Project__Inverter
XInverter@8 gnd net@300 net@2879 vdd Project__Inverter
XInverter@9 gnd net@209 net@2850 vdd Project__Inverter
XInverter@10 gnd net@233 net@2814 vdd Project__Inverter
XInverter@11 gnd net@219 net@2745 vdd Project__Inverter
XInverter@12 gnd net@253 net@2705 vdd Project__Inverter
XInverter@13 gnd net@269 net@2668 vdd Project__Inverter
XInverter@14 gnd net@708 net@705 vdd Project__Inverter
XInverter@15 gnd net@672 net@725 vdd Project__Inverter
XInverter@16 gnd net@739 net@743 vdd Project__Inverter
XInverter@17 gnd net@584 net@764 vdd Project__Inverter
XInverter@18 gnd net@785 net@786 vdd Project__Inverter
XInverter@19 gnd net@804 net@805 vdd Project__Inverter
XInverter@20 gnd net@641 net@939 vdd Project__Inverter
XInverter@21 gnd net@880 net@962 vdd Project__Inverter
XInverter@22 gnd net@566 net@991 vdd Project__Inverter
XInverter@23 gnd net@891 net@1015 vdd Project__Inverter
XInverter@24 gnd net@588 net@1040 vdd Project__Inverter
XInverter@25 gnd net@605 net@1070 vdd Project__Inverter
XInverter@38 gnd net@1588 net@2207 vdd Project__Inverter
XInverter@39 gnd net@1934 net@2225 vdd Project__Inverter
XInverter@40 gnd net@2004 net@2241 vdd Project__Inverter
XInverter@41 gnd net@1990 net@2260 vdd Project__Inverter
XInverter@42 gnd net@1474 net@1475 vdd Project__Inverter
XInverter@43 gnd net@1492 net@1493 vdd Project__Inverter
XInverter@44 gnd net@2149 net@2351 vdd Project__Inverter
XInverter@45 gnd net@2057 net@2373 vdd Project__Inverter
XInverter@46 gnd net@2081 net@2395 vdd Project__Inverter
XInverter@47 gnd net@2067 net@2421 vdd Project__Inverter
XInverter@48 gnd net@2101 net@2447 vdd Project__Inverter
XInverter@49 gnd net@2117 net@2469 vdd Project__Inverter
XInverter@56 gnd net@1876 net@1877 vdd Project__Inverter
XInverter@57 gnd net@1833 net@1893 vdd Project__Inverter
XInverter@58 gnd net@1514 net@1913 vdd Project__Inverter
XInverter@59 gnd net@1844 net@1931 vdd Project__Inverter
XInverter@60 gnd net@1536 net@1951 vdd Project__Inverter
XInverter@61 gnd net@1553 net@1969 vdd Project__Inverter
XMultipli@0 net@379 net@380 net@923 net@924 gnd net@46 net@317 net@917 net@921 net@64 vdd Project__Multiplier_Cell_Full
XMultipli@2 net@404 net@405 net@949 net@950 gnd net@46 net@323 net@641 net@939 net@102 vdd Project__Multiplier_Cell_Full
XMultipli@3 net@434 net@437 net@979 net@978 gnd net@46 net@328 net@880 net@962 net@128 vdd Project__Multiplier_Cell_Full
XMultipli@4 net@460 net@463 net@1002 net@1003 gnd net@46 net@335 net@566 net@991 net@113 vdd Project__Multiplier_Cell_Full
XMultipli@5 net@492 net@493 net@1027 net@1026 gnd net@46 net@340 net@891 net@1015 net@149 vdd Project__Multiplier_Cell_Full
XMultipli@8 net@516 net@519 net@1053 net@1056 gnd net@46 net@345 net@588 net@1040 net@189 vdd Project__Multiplier_Cell_Full
XMultipli@9 net@552 net@553 net@1083 net@1082 gnd net@46 net@350 net@605 net@1070 m[9] vdd Project__Multiplier_Cell_Full
XMultipli@10 net@2900 net@2901 net@379 net@380 gnd net@216 net@317 net@367 net@369 net@300 vdd Project__Multiplier_Cell_Full
XMultipli@11 net@2869 net@2870 net@404 net@405 gnd net@216 net@323 net@64 net@389 net@209 vdd Project__Multiplier_Cell_Full
XMultipli@12 net@2837 net@2836 net@434 net@437 gnd net@216 net@328 net@102 net@414 net@233 vdd Project__Multiplier_Cell_Full
XMultipli@13 net@2777 net@2780 net@460 net@463 gnd net@216 net@335 net@128 net@444 net@219 vdd Project__Multiplier_Cell_Full
XMultipli@14 net@2746 net@2747 net@492 net@493 gnd net@216 net@340 net@113 net@475 net@253 vdd Project__Multiplier_Cell_Full
XMultipli@15 net@2691 net@2690 net@516 net@519 gnd net@216 net@345 net@149 net@505 net@269 vdd Project__Multiplier_Cell_Full
XMultipli@16 net@2656 net@2657 net@552 net@553 gnd net@216 net@350 net@189 net@539 m[8] vdd Project__Multiplier_Cell_Full
XMultipli@17 net@696 net@698 net@2339 net@2338 gnd net@560 net@317 net@2332 net@2337 net@708 vdd Project__Multiplier_Cell_Full
XMultipli@18 net@716 net@718 net@2361 net@2360 gnd net@560 net@323 net@2149 net@2351 net@672 vdd Project__Multiplier_Cell_Full
XMultipli@19 net@734 net@735 net@2383 net@2382 gnd net@560 net@328 net@2057 net@2373 net@739 vdd Project__Multiplier_Cell_Full
XMultipli@20 net@753 net@754 net@2409 net@2408 gnd net@560 net@335 net@2081 net@2395 net@584 vdd Project__Multiplier_Cell_Full
XMultipli@21 net@774 net@775 net@2435 net@2434 gnd net@560 net@340 net@2067 net@2421 net@785 vdd Project__Multiplier_Cell_Full
XMultipli@22 net@794 net@796 net@2457 net@2456 gnd net@560 net@345 net@2101 net@2447 net@804 vdd Project__Multiplier_Cell_Full
XMultipli@23 net@813 net@814 net@2477 net@2476 gnd net@560 net@350 net@2117 net@2469 m[11] vdd Project__Multiplier_Cell_Full
XMultipli@24 net@923 net@924 net@696 net@698 gnd net@563 net@317 net@688 net@689 net@641 vdd Project__Multiplier_Cell_Full
XMultipli@25 net@949 net@950 net@716 net@718 gnd net@563 net@323 net@708 net@705 net@880 vdd Project__Multiplier_Cell_Full
XMultipli@26 net@979 net@978 net@734 net@735 gnd net@563 net@328 net@672 net@725 net@566 vdd Project__Multiplier_Cell_Full
XMultipli@27 net@1002 net@1003 net@753 net@754 gnd net@563 net@335 net@739 net@743 net@891 vdd Project__Multiplier_Cell_Full
XMultipli@28 net@1027 net@1026 net@774 net@775 gnd net@563 net@340 net@584 net@764 net@588 vdd Project__Multiplier_Cell_Full
XMultipli@29 net@1053 net@1056 net@794 net@796 gnd net@563 net@345 net@785 net@786 net@605 vdd Project__Multiplier_Cell_Full
XMultipli@30 net@1083 net@1082 net@813 net@814 gnd net@563 net@350 net@804 net@805 m[10] vdd Project__Multiplier_Cell_Full
XMultipli@45 net@2198 net@2200 net@1866 net@1867 gnd net@1473 net@317 net@3125 net@3131 net@1588 vdd Project__Multiplier_Cell_Full
XMultipli@46 net@2217 net@2218 net@1883 net@1884 gnd net@1473 net@323 net@1876 net@1877 net@1934 vdd Project__Multiplier_Cell_Full
XMultipli@47 net@2233 net@2234 net@1903 net@1902 gnd net@1473 net@328 net@1833 net@1893 net@2004 vdd Project__Multiplier_Cell_Full
XMultipli@48 net@2250 net@2251 net@1921 net@1922 gnd net@1473 net@335 net@1514 net@1913 net@1990 vdd Project__Multiplier_Cell_Full
XMultipli@49 net@2269 net@1471 net@1940 net@1939 gnd net@1473 net@340 net@1844 net@1931 net@1474 vdd Project__Multiplier_Cell_Full
XMultipli@50 net@1483 net@1484 net@1959 net@1960 gnd net@1473 net@345 net@1536 net@1951 net@1492 vdd Project__Multiplier_Cell_Full
XMultipli@51 net@1500 net@1501 net@1979 net@1978 gnd net@1473 net@350 net@1553 net@1969 m[13] vdd Project__Multiplier_Cell_Full
XMultipli@52 net@2339 net@2338 net@2198 net@2200 gnd net@2064 net@317 net@2191 net@2192 net@2149 vdd Project__Multiplier_Cell_Full
XMultipli@53 net@2361 net@2360 net@2217 net@2218 gnd net@2064 net@323 net@1588 net@2207 net@2057 vdd Project__Multiplier_Cell_Full
XMultipli@54 net@2383 net@2382 net@2233 net@2234 gnd net@2064 net@328 net@1934 net@2225 net@2081 vdd Project__Multiplier_Cell_Full
XMultipli@55 net@2409 net@2408 net@2250 net@2251 gnd net@2064 net@335 net@2004 net@2241 net@2067 vdd Project__Multiplier_Cell_Full
XMultipli@56 net@2435 net@2434 net@2269 net@1471 gnd net@2064 net@340 net@1990 net@2260 net@2101 vdd Project__Multiplier_Cell_Full
XMultipli@57 net@2457 net@2456 net@1483 net@1484 gnd net@2064 net@345 net@1474 net@1475 net@2117 vdd Project__Multiplier_Cell_Full
XMultipli@58 net@2477 net@2476 net@1500 net@1501 gnd net@2064 net@350 net@1492 net@1493 m[12] vdd Project__Multiplier_Cell_Full
XMultipli@67 net@1883 net@1884 net@2512 net@2513 gnd net@1511 net@323 net@2488 net@2489 net@1833 vdd Project__Multiplier_Cell_Full
XMultipli@68 net@1903 net@1902 net@1687 net@1688 gnd net@1511 net@328 net@2512 net@2513 net@1514 vdd Project__Multiplier_Cell_Full
XMultipli@69 net@1921 net@1922 net@2553 net@2552 gnd net@1511 net@335 net@1687 net@1688 net@1844 vdd Project__Multiplier_Cell_Full
XMultipli@70 net@1940 net@1939 net@1727 net@1728 gnd net@1511 net@340 net@2553 net@2552 net@1536 vdd Project__Multiplier_Cell_Full
XMultipli@71 net@1959 net@1960 net@2595 net@2594 gnd net@1511 net@345 net@1727 net@1728 net@1553 vdd Project__Multiplier_Cell_Full
XMultipli@73 net@1979 net@1978 m[15] gnd net@1511 net@350 net@2595 net@2594 m[14] vdd Project__Multiplier_Cell_Full_1Carry
XMultipli@74 net@2488 net@2489 gnd net@1511 net@317 net@1866 net@1867 net@1876 vdd Project__Multiplier_Cell_Mini
XMultipli@75 net@2746 net@2747 gnd net@2954 net@340 net@219 net@2745 m[5] vdd Project__Multiplier_Cell_Mini
XMultipli@76 net@2777 net@2780 gnd net@2954 net@335 net@233 net@2814 m[4] vdd Project__Multiplier_Cell_Mini
XMultipli@77 net@2900 net@2901 gnd net@2954 net@317 net@2912 net@2913 m[1] vdd Project__Multiplier_Cell_Mini
XMultipli@78 net@2656 net@2657 gnd net@2954 net@350 net@269 net@2668 m[7] vdd Project__Multiplier_Cell_Mini
XMultipli@79 net@2691 net@2690 gnd net@2954 net@345 net@253 net@2705 m[6] vdd Project__Multiplier_Cell_Mini
XMultipli@86 net@2837 net@2836 gnd net@2954 net@328 net@209 net@2850 m[3] vdd Project__Multiplier_Cell_Mini
XMultipli@87 net@2869 net@2870 gnd net@2954 net@323 net@300 net@2879 m[2] vdd Project__Multiplier_Cell_Mini

* Spice Code nodes in cell cell 'Multiplier_Unit{lay}'
.include C:\VLSI\C5_models.txt
Vdd vdd 0 DC 5
Ven en 0 DC 5
Va0 a[0] 0 DC 5
Va1 a[1] 0 DC 0
Va2 a[2] 0 DC 5
Va3 a[3] 0 DC 5
Va4 a[4] 0 DC 5
Va5 a[5] 0 DC 0
Va6 a[6] 0 DC 5
Va7 a[7] 0 DC 5
Vb0 b[0] 0 DC 5
Vb1 b[1] 0 DC 0
Vb2 b[2] 0 DC 5
Vb3 b[3] 0 DC 0
Vb4 b[4] 0 DC 5
Vb5 b[5] 0 DC 0
Vb6 b[6] 0 DC 5
Vb7 b[7] 0 DC 0
.tran 20n
.end
.END
