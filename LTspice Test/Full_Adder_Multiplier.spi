*** SPICE deck for cell Full_Adder_Multiplier{lay} from library Project
*** Created on Sal Ara 16, 2025 18:14:27
*** Last revised on Sal Ara 16, 2025 18:20:49
*** Written on Sal Ara 16, 2025 18:20:55 by Electric VLSI Design System, version 9.07
*** Layout tech: mocmos, foundry MOSIS
*** UC SPICE *** , MIN_RESIST 4.0, MIN_CAPAC 0.1FF

*** SUBCIRCUIT Project__Inverter FROM CELL Inverter{lay}
.SUBCKT Project__Inverter gnd in out vdd
Mnmos@0 out in gnd gnd N L=0.6U W=3U AS=24.75P AD=10.125P PS=37.5U PD=13.5U
Mpmos@0 out in vdd vdd P L=0.6U W=6U AS=35.1P AD=10.125P PS=44.1U PD=13.5U

* Spice Code nodes in cell cell 'Inverter{lay}'
.include C:\VLSI\C5_models.txt
.ENDS Project__Inverter

*** SUBCIRCUIT Project__Mux FROM CELL Mux{lay}
.SUBCKT Project__Mux gnd in0 in1 out sel sel_bar vdd
Mnmos@8 out sel_bar in0 gnd N L=0.6U W=3U AS=10.125P AD=6.75P PS=13.5U PD=7.5U
Mnmos@9 in1 sel out gnd N L=0.6U W=3U AS=6.75P AD=10.125P PS=7.5U PD=13.5U
Mpmos@9 out sel in0 vdd P L=0.6U W=6U AS=10.125P AD=6.75P PS=13.5U PD=7.5U
Mpmos@10 in1 sel_bar out vdd P L=0.6U W=6U AS=6.75P AD=10.125P PS=7.5U PD=13.5U

* Spice Code nodes in cell cell 'Mux{lay}'
.include C:\VLSI\C5_models.txt
.ENDS Project__Mux

*** SUBCIRCUIT Project__Xor FROM CELL Xor{lay}
.SUBCKT Project__Xor a a_bar b b_bar gnd out vdd
Mnmos@0 out a_bar b gnd N L=0.6U W=3U AS=10.125P AD=6.75P PS=13.5U PD=7.5U
Mnmos@1 b_bar a out gnd N L=0.6U W=3U AS=6.75P AD=10.125P PS=7.5U PD=13.5U
Mpmos@0 out a b vdd P L=0.6U W=6U AS=10.125P AD=6.75P PS=13.5U PD=7.5U
Mpmos@1 b_bar a_bar out vdd P L=0.6U W=6U AS=6.75P AD=10.125P PS=7.5U PD=13.5U

* Spice Code nodes in cell cell 'Xor{lay}'
.include C:\VLSI\C5_models.txt
.ENDS Project__Xor

*** TOP LEVEL CELL: Full_Adder_Multiplier{lay}
XInverter@1 gnd net@6 net@13 vdd Project__Inverter
XMux@0 gnd b cin cout net@6 net@13 vdd Project__Mux
XXor@1 a a_bar b b_bar gnd net@6 vdd Project__Xor
XXor@2 net@6 net@13 cin cin_bar gnd sum vdd Project__Xor

* Spice Code nodes in cell cell 'Full_Adder_Multiplier{lay}'
.include C:\VLSI\C5_models.txt
Vdd vdd 0 DC 5
Vcin cin 0 PULSE(0 5 20ns 1n 1n 20n 40n)
Vcin_b cin_bar 0 PULSE(5 0 20ns 1n 1n 20n 40n)
Vb b 0 PULSE(0 5 40ns 1n 1n 40n 80n)
Vb_b b_bar 0 PULSE(5 0 40ns 1n 1n 40n 80n)
Va a 0 PULSE(0 5 80ns 1n 1n 80n 160n)
Va_b a_bar 0 PULSE(5 0 80ns 1n 1n160n 160n)
.tran 160n
.end
.END
