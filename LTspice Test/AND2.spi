*** SPICE deck for cell AND2{lay} from library Project
*** Created on Paz Ara 14, 2025 00:18:56
*** Last revised on Paz Ara 14, 2025 19:30:11
*** Written on Paz Ara 14, 2025 19:30:15 by Electric VLSI Design System, version 9.07
*** Layout tech: mocmos, foundry MOSIS
*** UC SPICE *** , MIN_RESIST 4.0, MIN_CAPAC 0.1FF

*** SUBCIRCUIT Project__Inverter FROM CELL Inverter{lay}
.SUBCKT Project__Inverter gnd in out vdd
Mnmos@0 out in gnd gnd N L=0.6U W=3U AS=24.75P AD=10.125P PS=37.5U PD=13.5U
Mpmos@0 out in vdd vdd P L=0.6U W=6U AS=35.1P AD=10.125P PS=44.1U PD=13.5U

* Spice Code nodes in cell cell 'Inverter{lay}'
.include C:\VLSI\C5_models.txt
.ENDS Project__Inverter

*** SUBCIRCUIT Project__NAND2 FROM CELL NAND2{lay}
.SUBCKT Project__NAND2 a b gnd vdd y
Mnmos@0 net@55 b gnd gnd N L=0.6U W=4.5U AS=32.625P AD=4.05P PS=46.5U PD=6.3U
Mnmos@1 y a net@55 gnd N L=0.6U W=4.5U AS=4.05P AD=7.875P PS=6.3U PD=9.5U
Mpmos@0 y b vdd vdd P L=0.6U W=4.5U AS=23.625P AD=7.875P PS=30.3U PD=9.5U
Mpmos@1 vdd a y vdd P L=0.6U W=4.5U AS=7.875P AD=23.625P PS=9.5U PD=30.3U

* Spice Code nodes in cell cell 'NAND2{lay}'
.include C:\VLSI\C5_models.txt
.ENDS Project__NAND2

*** TOP LEVEL CELL: AND2{lay}
XInverter@0 gnd y_bar y vdd Project__Inverter
XNAND2@0 a b gnd vdd y_bar Project__NAND2

* Spice Code nodes in cell cell 'AND2{lay}'
.include C:\VLSI\C5_models.txt
Vdd vdd 0 DC 5
Va a 0 PULSE(0 5 40ns 1p 1p 40n 80n)
Vb b 0 PULSE(0 5 20ns 1p 1p 20n 40n)
.tran 80n
.end
.END
